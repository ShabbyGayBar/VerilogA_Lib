// VerilogA for VerilogAmsLib, adc_16bit_ideal, veriloga

`include "constants.vams"
`include "disciplines.vams"

`define NUM_ADC_BITS 16

module adc_16bit_ideal(in, clk, out);
input in, clk;
output [`NUM_ADC_BITS-1:0] out;

electrical in, clk, out[`NUM_ADC_BITS-1:0];

parameter real trise = 0 from [0:inf);
parameter real tfall = 0 from [0:inf);
parameter real tdel = 0 from [0:inf);
parameter real vlogic_high = 5;
parameter real vlogic_low = 0;
parameter real vtrans_clk = 2.5;
parameter real vref = 1.0;

real unconverted, halfref, out_val[0:`NUM_ADC_BITS-1];
integer i;
genvar j;

analog begin
	@(initial_step) begin
		halfref = vref / 2;
	end

	@(cross(V(vclk) - vtrans_clk, 1)) begin
		unconverted = V(vin);
		for (i = (`NUM_ADC_BITS-1); i >= 0 ; i = i - 1) begin
			out_val[i] = 0;
			if (unconverted > halfref) begin
				out_val[i] = vlogic_high;
				unconverted = unconverted - halfref;
			end else begin
				out_val[i] = vlogic_low;
			end
			unconverted = unconverted * 2;
		end
	end

	for (j = 0; j < `NUM_ADC_BITS; j = j + 1) begin // assign the outputs
		V(out[j]) <+ transition(out_val[j], tdel, trise, tfall);
	end
end

endmodule

`undef NUM_ADC_BITS
