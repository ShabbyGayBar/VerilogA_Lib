// VerilogA for VerilogAmsLib, comparator_dynamic, veriloga

`include "constants.vams"
`include "disciplines.vams"

module comparator_dynamic(clk, inp, inm, outp, outm);
input clk; // Start conversion when rise, Reset when fall
input inp, inm; // Input
output outp, outm; // Output

electrical clk, inp, inm, outp, outm;

parameter real offset = 0;
parameter real vlogic_high = 5;
parameter real vtrans = 2.5;
parameter real tdel = 3u from [0:inf);
parameter real trise = 1u from (0:inf);
parameter real tfall = 1u from (0:inf);

real inDiff;
integer outm_val, outp_val;
genvar i;

analog begin
	@(initial_step) begin
		outp_val = 1;
		outm_val = 1;
	end

	inDiff = V(inp) - V(inm) + offset;

	@(cross(V(clk) - vtrans, 1)) begin // Compare
		if (inDiff < 0) begin
			outp_val = 0;
			outm_val = 1;
		end else begin
			outm_val = 0;
			outp_val = 1;
		end
	end

	@(cross(V(clk) - vtrans, -1)) begin // Reset
		outp_val = 1;
		outm_val = 1;
	end

	V(outm) <+ transition(outm_val*vlogic_high, tdel, trise, tfall);
	V(outp) <+ transition(outp_val*vlogic_high, tdel, trise, tfall);
end

endmodule
